* Extracted by KLayout with SG13G2 LVS runset on : 19/08/2025 13:16

.SUBCKT FMD_QNC_ota_decoup AVSS AVDD VOUT IBIAS MINUS PLUS
M$1 AVSS AVSS \$16030 AVSS sg13_lv_nmos L=2u W=3u AS=0.795p AD=0.795p PS=5.56u
+ PD=5.56u
M$2 \$16030 \$16031 AVSS AVSS sg13_lv_nmos L=2u W=3u AS=0.57p AD=0.57p PS=3.76u
+ PD=3.76u
M$5 AVSS AVSS \$16032 AVSS sg13_lv_nmos L=2u W=3u AS=0.795p AD=0.795p PS=5.56u
+ PD=5.56u
M$6 \$16032 \$16031 AVSS AVSS sg13_lv_nmos L=2u W=3u AS=0.57p AD=0.57p PS=3.76u
+ PD=3.76u
M$9 AVSS AVSS \$16140 AVSS sg13_lv_nmos L=2u W=3u AS=0.795p AD=0.795p PS=5.56u
+ PD=5.56u
M$10 \$16140 \$16140 AVSS AVSS sg13_lv_nmos L=2u W=3u AS=0.57p AD=0.57p
+ PS=3.76u PD=3.76u
M$11 AVSS \$16140 \$16342 AVSS sg13_lv_nmos L=2u W=3u AS=0.57p AD=0.57p
+ PS=3.76u PD=3.76u
M$15 AVSS AVSS \$16031 AVSS sg13_lv_nmos L=2u W=3u AS=0.795p AD=0.795p PS=5.56u
+ PD=5.56u
M$16 \$16031 \$16342 \$16030 AVSS sg13_lv_nmos L=2u W=3u AS=0.57p AD=0.57p
+ PS=3.76u PD=3.76u
M$19 AVSS AVSS VOUT AVSS sg13_lv_nmos L=2u W=3u AS=0.795p AD=0.795p PS=5.56u
+ PD=5.56u
M$20 VOUT \$16342 \$16032 AVSS sg13_lv_nmos L=2u W=3u AS=0.57p AD=0.57p
+ PS=3.76u PD=3.76u
M$23 AVDD VOUT \$16342 AVSS sg13_lv_nmos L=0.5u W=15u AS=3.4125p AD=3.4125p
+ PS=20.57u PD=20.57u
M$27 AVSS IBIAS IBIAS AVSS sg13_lv_nmos L=5u W=8.5u AS=1.93375p AD=1.93375p
+ PS=12.445u PD=12.445u
M$31 AVSS IBIAS \$16908 AVSS sg13_lv_nmos L=5u W=8.5u AS=1.93375p AD=1.93375p
+ PS=12.445u PD=12.445u
M$35 AVSS IBIAS \$16871 AVSS sg13_lv_nmos L=5u W=8.5u AS=1.93375p AD=1.93375p
+ PS=12.445u PD=12.445u
M$39 AVSS AVSS \$16985 AVSS sg13_lv_nmos L=1u W=6u AS=1.59p AD=1.59p PS=10.06u
+ PD=10.06u
M$40 \$16985 MINUS \$16871 AVSS sg13_lv_nmos L=1u W=6u AS=1.14p AD=1.14p
+ PS=6.76u PD=6.76u
M$41 \$16871 PLUS \$16986 AVSS sg13_lv_nmos L=1u W=6u AS=1.14p AD=1.14p
+ PS=6.76u PD=6.76u
M$42 \$16986 AVSS AVSS AVSS sg13_lv_nmos L=1u W=6u AS=1.59p AD=1.59p PS=10.06u
+ PD=10.06u
M$47 AVDD AVDD \$16985 AVDD sg13_lv_pmos L=2u W=14u AS=3.185p AD=3.185p
+ PS=19.32u PD=19.32u
M$49 AVDD \$16909 \$16986 AVDD sg13_lv_pmos L=2u W=14u AS=2.66p AD=2.66p
+ PS=15.52u PD=15.52u
M$51 AVDD \$16909 \$16985 AVDD sg13_lv_pmos L=2u W=14u AS=2.66p AD=2.66p
+ PS=15.52u PD=15.52u
M$59 AVDD AVDD \$16031 AVDD sg13_lv_pmos L=2u W=7u AS=1.855p AD=1.855p
+ PS=11.56u PD=11.56u
M$60 \$16031 \$17417 \$16986 AVDD sg13_lv_pmos L=2u W=14u AS=2.66p AD=2.66p
+ PS=15.52u PD=15.52u
M$65 \$16908 \$16031 \$16909 AVDD sg13_lv_pmos L=2u W=14u AS=3.185p AD=3.185p
+ PS=19.32u PD=19.32u
M$69 AVDD AVDD \$16909 AVDD sg13_lv_pmos L=2u W=7u AS=1.855p AD=1.855p
+ PS=11.56u PD=11.56u
M$70 \$16909 \$16909 AVDD AVDD sg13_lv_pmos L=2u W=14u AS=2.66p AD=2.66p
+ PS=15.52u PD=15.52u
M$71 AVDD \$16909 \$17417 AVDD sg13_lv_pmos L=2u W=14u AS=2.66p AD=2.66p
+ PS=15.52u PD=15.52u
M$73 AVDD \$16909 \$17736 AVDD sg13_lv_pmos L=2u W=14u AS=2.66p AD=2.66p
+ PS=15.52u PD=15.52u
M$83 AVSS \$16031 \$17417 AVDD sg13_lv_pmos L=0.5u W=14u AS=3.185p AD=3.185p
+ PS=19.32u PD=19.32u
M$87 AVDD AVDD VOUT AVDD sg13_lv_pmos L=2u W=7u AS=1.855p AD=1.855p PS=11.56u
+ PD=11.56u
M$88 VOUT \$17417 \$16985 AVDD sg13_lv_pmos L=2u W=14u AS=2.66p AD=2.66p
+ PS=15.52u PD=15.52u
C$93 VOUT AVSS cap_cmim w=25.82u l=25.82u A=666.6724p P=103.28u m=1
M$94 \$16140 VOUT \$17736 AVSS sg13_lv_nmos L=2u W=3u AS=0.795p AD=0.795p
+ PS=5.56u PD=5.56u
M$96 AVDD \$16909 AVDD AVDD sg13_lv_pmos L=0.5u W=12u AS=2.73p AD=2.73p
+ PS=16.82u PD=16.82u
M$100 AVDD \$17417 AVDD AVDD sg13_lv_pmos L=0.5u W=12u AS=2.73p AD=2.73p
+ PS=16.82u PD=16.82u
M$104 AVSS IBIAS AVSS AVSS sg13_lv_nmos L=1u W=8u AS=1.82p AD=1.82p PS=11.82u
+ PD=11.82u
M$108 AVSS \$16342 AVSS AVSS sg13_lv_nmos L=1u W=8u AS=1.82p AD=1.82p PS=11.82u
+ PD=11.82u
D$112 AVSS AVDD IBIAS diodevdd_2kv m=1
D$113 AVSS AVDD AVSS diodevdd_2kv m=1
D$114 AVSS AVDD AVDD diodevdd_2kv m=1
D$115 AVSS AVDD VOUT diodevdd_2kv m=1
D$116 AVSS AVDD MINUS diodevdd_2kv m=1
D$117 AVSS AVDD PLUS diodevdd_2kv m=1
D$118 AVDD AVSS AVSS diodevss_2kv m=1
D$119 AVDD AVSS AVDD diodevss_2kv m=1
D$120 AVDD AVSS VOUT diodevss_2kv m=1
D$121 AVDD AVSS IBIAS diodevss_2kv m=1
D$122 AVDD AVSS MINUS diodevss_2kv m=1
D$123 AVDD AVSS PLUS diodevss_2kv m=1
.ENDS FMD_QNC_ota_decoup
